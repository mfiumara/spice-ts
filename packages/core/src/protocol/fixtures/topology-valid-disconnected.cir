V1 a 0 1
R1 a 0 1k
V2 b 0 2
R2 b 0 2k
.op
