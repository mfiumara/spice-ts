V1 in 0 1
C1 in sense 1u
I1 sense 0 1m
.op
