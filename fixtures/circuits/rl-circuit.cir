* RL circuit with pulse input
V1 1 0 PULSE(0 5 0 1n 1n 5m 10m)
R1 1 2 100
L1 2 0 10m
.tran 1u 0.5m
.end
