MIT-authored smoothed TABLE AC derivative
Vinput in 0 DC 0 AC 1
Elookup out 0 TABLE {v(in)} = (-1,-2) (0,0) (1,3)
Rload out 0 1k
.ac lin 1 1 1
.end
