MIT-authored E TABLE sweep, endpoint clamps and smoothed corners
Vinput in 0 0
Elookup out 0 TABLE {v(in)} = (-1,-2) (0,0) (1,3)
Rload out 0 1k
.dc Vinput -2 2 0.05
.end
