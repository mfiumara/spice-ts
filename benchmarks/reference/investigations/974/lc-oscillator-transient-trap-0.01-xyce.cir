*oscillator, .159 Hz.
C1 1 0 1
L1 1 0 1
i1 1 0 pwl 0 5 .1 0

.tran .5 100 0 .01
.options timeint method=7 reltol=1e-6
.print TRAN format=csv file=output.csv precision=17 I(l1) V(1)
.end
