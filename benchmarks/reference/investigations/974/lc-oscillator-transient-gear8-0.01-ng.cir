*oscillator, .159 Hz.
C1 1 0 1
L1 1 0 1
i1 1 0 pwl 0 5 .1 0

.tran .5 100 0 .01
.options method=gear reltol=1e-6 trtol=1
.end
