* Resistive partition with different ratios for AC/DC (Print V(2))

vin 1 0 DC 1V AC 1V
r1  1 2 5K
r2  2 0 5K ac=15k

.AC DEC 10 1 10K
.print AC format=csv file=output.csv precision=17 IR(vin) II(vin) VR(1) VI(1) VR(2) VI(2)
.END
