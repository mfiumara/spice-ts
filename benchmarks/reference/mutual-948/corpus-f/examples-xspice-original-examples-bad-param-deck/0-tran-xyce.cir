Unknown code model parameter
*
* This circuit contains a simple gain block to demonstrate
* that the simulator reports an error if the .model card
* references a parameter that doesn't exist
*
.tran 1e-5 1e-3
*
v1 1 0 0.0 sin(0 1 1k)
r1 1 0 1k
*
a1 1 2 gain_block
.model gain_block gain (this_parameter_doesnt_exist=2 gain=10)
r2 2 0 1k
*
.print TRAN format=csv file=output.csv precision=17 I(a1) I(v1) V(1) V(2)
.end
