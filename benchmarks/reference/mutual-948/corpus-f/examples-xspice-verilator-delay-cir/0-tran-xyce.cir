* Waveform generation by Verilog delays
*

adut null [ d4 d3 d2 d1 d0 ] ring
.model ring d_cosim simulation="./delay"

.tran 20u 100u
.print TRAN format=csv file=output.csv precision=17 V(0)
.end
