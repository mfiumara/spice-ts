VDMOS output

m1 d g s IRFZ48Z

.model IRFZ48Z VDMOS (Rg = 1.77 Vto=4 Rd=1.85m Rs=0.0m Rb=3.75m Kp=25 Cgdmax=2.1n Cgdmin=0.05n Cgs=1.8n Cjo=0.55n Is=2.5p tt=20n ksubthres=0.1 mfg=International_Rectifier Vds=55 Ron=8.6m Qg=43n)

vd d 0 1
vg g 0 1
vs s 0 0

.dc vg 2 7 0.05 vd 0.5 2.5 0.5

.print DC format=csv file=output.csv precision=17 {vg} I(vd) I(vg) I(vs) V(d) V(g) V(m1#body_diode) V(m1#gate) V(s)
.end
