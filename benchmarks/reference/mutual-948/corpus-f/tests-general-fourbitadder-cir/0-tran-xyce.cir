4 bit adder

* Models:
.MODEL dmod D
.MODEL qmod NPN(level=1 BF=75 RB=100 CJE=1PF CJC=3PF)

.SUBCKT NAND 1 2 3 4
* noeuds: entrees(2) sortie vcc
q1 9 5 1 qmod
d1clamp 0 1 dmod
q2 9 5 2 qmod
d2clamp 0 2 dmod
rb 4 5 4k
r1 4 6 1.6k
q3 6 9 8 qmod
r2 8 0 1k
rc 4 7 130
q4 7 6 10 qmod
dvbedrop 10 3 dmod
q5 3 8 0 qmod
.ends NAND

.SUBCKT ONEBIT 1 2 3 4 5 6
* noeuds entrees(2) ,carryin, sortie, carryout, vcc
x1 1 2 7 6 NAND
x2 1 7 8 6 NAND
x3 2 7 9 6 NAND
x4 8 9 10 6 NAND
x5 3 10 11 6 NAND
x6 3 11 12 6 NAND
x7 10 11 13 6 NAND
x8 12 13 4 6 NAND
x9 11 7 5 6 NAND
.ends ONEBIT

.SUBCKT TWOBIT 1 2 3 4 5 6 7 8 9
* noeuds
x1 1 2 7 5 10 9 ONEBIT
x2 3 4 10 6 8 9 ONEBIT
.ends TWOBIT

.SUBCKT FOURBIT 1 2 3 4 5 6 7 8 9 10 11 12 13 14 15

x1 1 2 3 4 9 10 13 16 15 TWOBIT
x2 5 6 7 8 11 12 16 14 15 TWOBIT
.ends FOURBIT

* Inputs/Supplies:

vcc 99 0 DC 5V
VIN1A 1 0 DC 0 pulse(0 3 0 10ns 10ns   10ns   50ns)
VIN1B 2 0 DC 0 pulse(0 3 0 10ns 10ns   20ns  100ns)
VIN2A 3 0 DC 0 pulse(0 3 0 10ns 10ns   40ns  200ns)
VIN2B 4 0 DC 0 pulse(0 3 0 10ns 10ns   80ns  400ns)
VIN3A 5 0 DC 0 pulse(0 3 0 10ns 10ns  160ns  800ns)
VIN3B 6 0 DC 0 pulse(0 3 0 10ns 10ns  320ns 1600ns)
VIN4A 7 0 DC 0 pulse(0 3 0 10ns 10ns  640ns 3200ns)
VIN4B 8 0 DC 0 pulse(0 3 0 10ns 10ns 1280ns 6400ns)

* Circuit description:
x1 1 2 3 4 5 6 7 8 9 10 11 12 0 13 99 FOURBIT
rbit0 9 0 1k
rbit1 10 0 1k
rbit2 11 0 1k
rbit3 12 0 1k
rcout 13 0 1k

* Analysys:
.tran 1ns 6ns

.print TRAN format=csv file=output.csv precision=17 I(vcc) I(vin1a) I(vin1b) I(vin2a) I(vin2b) I(vin3a) I(vin3b) I(vin4a) I(vin4b) V(1) V(10) V(11) V(12) V(13) V(2) V(3) V(4) V(5) V(6) V(7) V(8) V(9) V(99) V(x1.16) V(x1.x1.10) V(x1.x1.x1.10) V(x1.x1.x1.11) V(x1.x1.x1.12) V(x1.x1.x1.13) V(x1.x1.x1.7) V(x1.x1.x1.8) V(x1.x1.x1.9) V(x1.x1.x1.x1.10) V(x1.x1.x1.x1.5) V(x1.x1.x1.x1.6) V(x1.x1.x1.x1.7) V(x1.x1.x1.x1.8) V(x1.x1.x1.x1.9) V(x1.x1.x1.x2.10) V(x1.x1.x1.x2.5) V(x1.x1.x1.x2.6) V(x1.x1.x1.x2.7) V(x1.x1.x1.x2.8) V(x1.x1.x1.x2.9) V(x1.x1.x1.x3.10) V(x1.x1.x1.x3.5) V(x1.x1.x1.x3.6) V(x1.x1.x1.x3.7) V(x1.x1.x1.x3.8) V(x1.x1.x1.x3.9) V(x1.x1.x1.x4.10) V(x1.x1.x1.x4.5) V(x1.x1.x1.x4.6) V(x1.x1.x1.x4.7) V(x1.x1.x1.x4.8) V(x1.x1.x1.x4.9) V(x1.x1.x1.x5.10) V(x1.x1.x1.x5.5) V(x1.x1.x1.x5.6) V(x1.x1.x1.x5.7) V(x1.x1.x1.x5.8) V(x1.x1.x1.x5.9) V(x1.x1.x1.x6.10) V(x1.x1.x1.x6.5) V(x1.x1.x1.x6.6) V(x1.x1.x1.x6.7) V(x1.x1.x1.x6.8) V(x1.x1.x1.x6.9) V(x1.x1.x1.x7.10) V(x1.x1.x1.x7.5) V(x1.x1.x1.x7.6) V(x1.x1.x1.x7.7) V(x1.x1.x1.x7.8) V(x1.x1.x1.x7.9) V(x1.x1.x1.x8.10) V(x1.x1.x1.x8.5) V(x1.x1.x1.x8.6) V(x1.x1.x1.x8.7) V(x1.x1.x1.x8.8) V(x1.x1.x1.x8.9) V(x1.x1.x1.x9.10) V(x1.x1.x1.x9.5) V(x1.x1.x1.x9.6) V(x1.x1.x1.x9.7) V(x1.x1.x1.x9.8) V(x1.x1.x1.x9.9) V(x1.x1.x2.10) V(x1.x1.x2.11) V(x1.x1.x2.12) V(x1.x1.x2.13) V(x1.x1.x2.7) V(x1.x1.x2.8) V(x1.x1.x2.9) V(x1.x1.x2.x1.10) V(x1.x1.x2.x1.5) V(x1.x1.x2.x1.6) V(x1.x1.x2.x1.7) V(x1.x1.x2.x1.8) V(x1.x1.x2.x1.9) V(x1.x1.x2.x2.10) V(x1.x1.x2.x2.5) V(x1.x1.x2.x2.6) V(x1.x1.x2.x2.7) V(x1.x1.x2.x2.8) V(x1.x1.x2.x2.9) V(x1.x1.x2.x3.10) V(x1.x1.x2.x3.5) V(x1.x1.x2.x3.6) V(x1.x1.x2.x3.7) V(x1.x1.x2.x3.8) V(x1.x1.x2.x3.9) V(x1.x1.x2.x4.10) V(x1.x1.x2.x4.5) V(x1.x1.x2.x4.6) V(x1.x1.x2.x4.7) V(x1.x1.x2.x4.8) V(x1.x1.x2.x4.9) V(x1.x1.x2.x5.10) V(x1.x1.x2.x5.5) V(x1.x1.x2.x5.6) V(x1.x1.x2.x5.7) V(x1.x1.x2.x5.8) V(x1.x1.x2.x5.9) V(x1.x1.x2.x6.10) V(x1.x1.x2.x6.5) V(x1.x1.x2.x6.6) V(x1.x1.x2.x6.7) V(x1.x1.x2.x6.8) V(x1.x1.x2.x6.9) V(x1.x1.x2.x7.10) V(x1.x1.x2.x7.5) V(x1.x1.x2.x7.6) V(x1.x1.x2.x7.7) V(x1.x1.x2.x7.8) V(x1.x1.x2.x7.9) V(x1.x1.x2.x8.10) V(x1.x1.x2.x8.5) V(x1.x1.x2.x8.6) V(x1.x1.x2.x8.7) V(x1.x1.x2.x8.8) V(x1.x1.x2.x8.9) V(x1.x1.x2.x9.10) V(x1.x1.x2.x9.5) V(x1.x1.x2.x9.6) V(x1.x1.x2.x9.7) V(x1.x1.x2.x9.8) V(x1.x1.x2.x9.9) V(x1.x2.10) V(x1.x2.x1.10) V(x1.x2.x1.11) V(x1.x2.x1.12) V(x1.x2.x1.13) V(x1.x2.x1.7) V(x1.x2.x1.8) V(x1.x2.x1.9) V(x1.x2.x1.x1.10) V(x1.x2.x1.x1.5) V(x1.x2.x1.x1.6) V(x1.x2.x1.x1.7) V(x1.x2.x1.x1.8) V(x1.x2.x1.x1.9) V(x1.x2.x1.x2.10) V(x1.x2.x1.x2.5) V(x1.x2.x1.x2.6) V(x1.x2.x1.x2.7) V(x1.x2.x1.x2.8) V(x1.x2.x1.x2.9) V(x1.x2.x1.x3.10) V(x1.x2.x1.x3.5) V(x1.x2.x1.x3.6) V(x1.x2.x1.x3.7) V(x1.x2.x1.x3.8) V(x1.x2.x1.x3.9) V(x1.x2.x1.x4.10) V(x1.x2.x1.x4.5) V(x1.x2.x1.x4.6) V(x1.x2.x1.x4.7) V(x1.x2.x1.x4.8) V(x1.x2.x1.x4.9) V(x1.x2.x1.x5.10) V(x1.x2.x1.x5.5) V(x1.x2.x1.x5.6) V(x1.x2.x1.x5.7) V(x1.x2.x1.x5.8) V(x1.x2.x1.x5.9) V(x1.x2.x1.x6.10) V(x1.x2.x1.x6.5) V(x1.x2.x1.x6.6) V(x1.x2.x1.x6.7) V(x1.x2.x1.x6.8) V(x1.x2.x1.x6.9) V(x1.x2.x1.x7.10) V(x1.x2.x1.x7.5) V(x1.x2.x1.x7.6) V(x1.x2.x1.x7.7) V(x1.x2.x1.x7.8) V(x1.x2.x1.x7.9) V(x1.x2.x1.x8.10) V(x1.x2.x1.x8.5) V(x1.x2.x1.x8.6) V(x1.x2.x1.x8.7) V(x1.x2.x1.x8.8) V(x1.x2.x1.x8.9) V(x1.x2.x1.x9.10) V(x1.x2.x1.x9.5) V(x1.x2.x1.x9.6) V(x1.x2.x1.x9.7) V(x1.x2.x1.x9.8) V(x1.x2.x1.x9.9) V(x1.x2.x2.10) V(x1.x2.x2.11) V(x1.x2.x2.12) V(x1.x2.x2.13) V(x1.x2.x2.7) V(x1.x2.x2.8) V(x1.x2.x2.9) V(x1.x2.x2.x1.10) V(x1.x2.x2.x1.5) V(x1.x2.x2.x1.6) V(x1.x2.x2.x1.7) V(x1.x2.x2.x1.8) V(x1.x2.x2.x1.9) V(x1.x2.x2.x2.10) V(x1.x2.x2.x2.5) V(x1.x2.x2.x2.6) V(x1.x2.x2.x2.7) V(x1.x2.x2.x2.8) V(x1.x2.x2.x2.9) V(x1.x2.x2.x3.10) V(x1.x2.x2.x3.5) V(x1.x2.x2.x3.6) V(x1.x2.x2.x3.7) V(x1.x2.x2.x3.8) V(x1.x2.x2.x3.9) V(x1.x2.x2.x4.10) V(x1.x2.x2.x4.5) V(x1.x2.x2.x4.6) V(x1.x2.x2.x4.7) V(x1.x2.x2.x4.8) V(x1.x2.x2.x4.9) V(x1.x2.x2.x5.10) V(x1.x2.x2.x5.5) V(x1.x2.x2.x5.6) V(x1.x2.x2.x5.7) V(x1.x2.x2.x5.8) V(x1.x2.x2.x5.9) V(x1.x2.x2.x6.10) V(x1.x2.x2.x6.5) V(x1.x2.x2.x6.6) V(x1.x2.x2.x6.7) V(x1.x2.x2.x6.8) V(x1.x2.x2.x6.9) V(x1.x2.x2.x7.10) V(x1.x2.x2.x7.5) V(x1.x2.x2.x7.6) V(x1.x2.x2.x7.7) V(x1.x2.x2.x7.8) V(x1.x2.x2.x7.9) V(x1.x2.x2.x8.10) V(x1.x2.x2.x8.5) V(x1.x2.x2.x8.6) V(x1.x2.x2.x8.7) V(x1.x2.x2.x8.8) V(x1.x2.x2.x8.9) V(x1.x2.x2.x9.10) V(x1.x2.x2.x9.5) V(x1.x2.x2.x9.6) V(x1.x2.x2.x9.7) V(x1.x2.x2.x9.8) V(x1.x2.x2.x9.9)
.end
