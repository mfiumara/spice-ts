capacitive bandpass filter
v1 1 0 dc 0 ac 1 ; sin
r1 1 2 200
c1 2 0 5u
c2 2 3 1u
rload 3 0 1k
.ac lin 50 20 1000
.print AC format=csv file=output.csv precision=17 IR(v1) II(v1) VR(1) VI(1) VR(2) VI(2) VR(3) VI(3)
.end
