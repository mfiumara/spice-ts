check that we can survive emptiness

* (exec-spice "ngspice -b %s")

* Nothingness, No circuit elements at all.
*   We have only the implicit node "0"
* Checks whether we can live with a
*   zero times zero circuit matrix

.ac lin 3 1kHz 2kHz

.end
