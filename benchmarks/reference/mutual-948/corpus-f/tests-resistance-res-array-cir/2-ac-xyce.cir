A paralled resistor array

Vin 1 0 DC 1 SIN (0 1 100MEG 1NS 0.0) AC 1

VR1 1 2 DC 0
R1  2 0 10K

VR2 1 3 DC 0
R2  3 0 10K ac=5K

VR3 1 4 DC 0
R3  4 0 rmodel1 L=11u W=2u ac=2.5k

VR4 1 5 DC 0
R4  5 0 10K ac=5k m=2
.model rmodel1 R  RSH = 1000 NARROW = 1u

VR5 1 6 DC 0
R5  6 0 10 ac=5 scale=1K

.AC DEC 100 1MEG 100MEG

.print AC format=csv file=output.csv precision=17 IR(vin) II(vin) IR(vr1) II(vr1) IR(vr2) II(vr2) IR(vr3) II(vr3) IR(vr4) II(vr4) IR(vr5) II(vr5) VR(1) VI(1) VR(2) VI(2) VR(3) VI(3) VR(4) VI(4) VR(5) VI(5) VR(6) VI(6)
.END
