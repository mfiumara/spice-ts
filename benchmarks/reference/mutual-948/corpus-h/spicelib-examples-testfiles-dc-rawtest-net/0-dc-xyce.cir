* DC directive
V1 R 0 10
R1 R 0 1000
.dc V1 0 5 1
.print DC format=csv file=output.csv precision=17 {V1} I(v1) V(r)
.end
