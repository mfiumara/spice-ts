Test
I1 1 0 AC 1
R1 1 0 10
.AC LIN 1000 1 1000
.END
