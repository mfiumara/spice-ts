* C:\sandbox\PyLTSpice_GitHub_nunobrum\tests\rc_example.asc
V1 in 0 10V
R1 out in 1k
C1 out 0 1u
.op
.print DC format=csv file=output.csv precision=17 I(v1) V(in) V(out)
.end
