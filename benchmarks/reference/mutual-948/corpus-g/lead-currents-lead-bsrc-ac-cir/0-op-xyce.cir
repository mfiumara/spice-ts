* Lead current test for E and H sources, and the
* voltage form of a B-source, for a .AC analysis

* RESISTOR DIVIDER
V1  1 0 DC 5.0 AC  1.0
R1  1 2 1
R2  2 0 1
*
* AMP AND LP FILTER
EAMP  3 0 2 0 1
RLP1  3 4 100
CLP1  4 0 1.59NF

H5 5 0 V1 1
R5 5 0 1

B6 6 0 V={V(4)}
R6 6 0 1

.OP

.print DC format=csv file=output.csv precision=17 I(b6) I(eamp) I(h5) I(v1) V(1) V(2) V(3) V(4) V(5) V(6)
.END
