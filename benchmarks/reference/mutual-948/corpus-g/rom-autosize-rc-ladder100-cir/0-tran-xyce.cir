* 100 stage RC Ladder.
*
* Generated by running RC_ladder.pl 100 <return>, where 100 is the number of resistor
* with shunt capacitor subcircuits in series.
*
* Author: Heidi Thornquist
* Date: 04/15/2008
*
Vs 1 0 PULSE(1 2 25e-9 25n 25n 400n 1m)

.subckt RCBlock IN OUT GND
R1 IN OUT 20
C1 OUT GND 1p
.ends

X1 1 2 0 RCBlock
X2 2 3 0 RCBlock
X3 3 4 0 RCBlock
X4 4 5 0 RCBlock
X5 5 6 0 RCBlock
X6 6 7 0 RCBlock
X7 7 8 0 RCBlock
X8 8 9 0 RCBlock
X9 9 10 0 RCBlock
X10 10 11 0 RCBlock
X11 11 12 0 RCBlock
X12 12 13 0 RCBlock
X13 13 14 0 RCBlock
X14 14 15 0 RCBlock
X15 15 16 0 RCBlock
X16 16 17 0 RCBlock
X17 17 18 0 RCBlock
X18 18 19 0 RCBlock
X19 19 20 0 RCBlock
X20 20 21 0 RCBlock
X21 21 22 0 RCBlock
X22 22 23 0 RCBlock
X23 23 24 0 RCBlock
X24 24 25 0 RCBlock
X25 25 26 0 RCBlock
X26 26 27 0 RCBlock
X27 27 28 0 RCBlock
X28 28 29 0 RCBlock
X29 29 30 0 RCBlock
X30 30 31 0 RCBlock
X31 31 32 0 RCBlock
X32 32 33 0 RCBlock
X33 33 34 0 RCBlock
X34 34 35 0 RCBlock
X35 35 36 0 RCBlock
X36 36 37 0 RCBlock
X37 37 38 0 RCBlock
X38 38 39 0 RCBlock
X39 39 40 0 RCBlock
X40 40 41 0 RCBlock
X41 41 42 0 RCBlock
X42 42 43 0 RCBlock
X43 43 44 0 RCBlock
X44 44 45 0 RCBlock
X45 45 46 0 RCBlock
X46 46 47 0 RCBlock
X47 47 48 0 RCBlock
X48 48 49 0 RCBlock
X49 49 50 0 RCBlock
X50 50 51 0 RCBlock
X51 51 52 0 RCBlock
X52 52 53 0 RCBlock
X53 53 54 0 RCBlock
X54 54 55 0 RCBlock
X55 55 56 0 RCBlock
X56 56 57 0 RCBlock
X57 57 58 0 RCBlock
X58 58 59 0 RCBlock
X59 59 60 0 RCBlock
X60 60 61 0 RCBlock
X61 61 62 0 RCBlock
X62 62 63 0 RCBlock
X63 63 64 0 RCBlock
X64 64 65 0 RCBlock
X65 65 66 0 RCBlock
X66 66 67 0 RCBlock
X67 67 68 0 RCBlock
X68 68 69 0 RCBlock
X69 69 70 0 RCBlock
X70 70 71 0 RCBlock
X71 71 72 0 RCBlock
X72 72 73 0 RCBlock
X73 73 74 0 RCBlock
X74 74 75 0 RCBlock
X75 75 76 0 RCBlock
X76 76 77 0 RCBlock
X77 77 78 0 RCBlock
X78 78 79 0 RCBlock
X79 79 80 0 RCBlock
X80 80 81 0 RCBlock
X81 81 82 0 RCBlock
X82 82 83 0 RCBlock
X83 83 84 0 RCBlock
X84 84 85 0 RCBlock
X85 85 86 0 RCBlock
X86 86 87 0 RCBlock
X87 87 88 0 RCBlock
X88 88 89 0 RCBlock
X89 89 90 0 RCBlock
X90 90 91 0 RCBlock
X91 91 92 0 RCBlock
X92 92 93 0 RCBlock
X93 93 94 0 RCBlock
X94 94 95 0 RCBlock
X95 95 96 0 RCBlock
X96 96 97 0 RCBlock
X97 97 98 0 RCBlock
X98 98 99 0 RCBlock
X99 99 100 0 RCBlock
X100 100 101 0 RCBlock

.tran 10p 1.2us

.print TRAN format=csv file=output.csv precision=17 I(vs) V(1) V(10) V(100) V(101) V(11) V(12) V(13) V(14) V(15) V(16) V(17) V(18) V(19) V(2) V(20) V(21) V(22) V(23) V(24) V(25) V(26) V(27) V(28) V(29) V(3) V(30) V(31) V(32) V(33) V(34) V(35) V(36) V(37) V(38) V(39) V(4) V(40) V(41) V(42) V(43) V(44) V(45) V(46) V(47) V(48) V(49) V(5) V(50) V(51) V(52) V(53) V(54) V(55) V(56) V(57) V(58) V(59) V(6) V(60) V(61) V(62) V(63) V(64) V(65) V(66) V(67) V(68) V(69) V(7) V(70) V(71) V(72) V(73) V(74) V(75) V(76) V(77) V(78) V(79) V(8) V(80) V(81) V(82) V(83) V(84) V(85) V(86) V(87) V(88) V(89) V(9) V(90) V(91) V(92) V(93) V(94) V(95) V(96) V(97) V(98) V(99)
.end
