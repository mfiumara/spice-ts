.tran 1ns 1ms
.global g

r1   1   0   1
v3  g  0  1

xg  g 1  abc

.subckt abc g a
r2  g a 2
.ends

.print TRAN format=csv file=output.csv precision=17 I(v3) V(1) V(g)
.end
