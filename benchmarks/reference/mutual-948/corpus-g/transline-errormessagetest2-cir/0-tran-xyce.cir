Transmission Line Circuit
*********************************************************************
* This tests the error messages generated by the T device.
*
* TLINE1 tests the error messages if the F parameter is not
* specified.  It has a default of zero, which would not produce a
* valid value for the time delay.
*
* TLINE2 tests the error message if both the TD and (F,NL) parameters
*
*
*********************************************************************
VIN 1 0 PULSE(0 5 0 0.1N 0.1N 5N 25N)
RIN 1 2 50

* A lossless transmission line can specify either TD or the
* combination of F and NL.  If NL is specified then F must
* also be specified.
TLINE1 2 0 3 0 Z0=50 NL=10
TLINE2 2 0 3 0 Z0=50 TD=10ns F=1GHZ NL=10

RL 3 0 50
.TRAN 0.25N 50N
.print TRAN format=csv file=output.csv precision=17 I(vin) V(1) V(2) V(3) V(tline1#i1) V(tline1#i2) V(tline1#int1) V(tline1#int2) V(tline2#i1) V(tline2#i2) V(tline2#int1) V(tline2#int2)
.END
