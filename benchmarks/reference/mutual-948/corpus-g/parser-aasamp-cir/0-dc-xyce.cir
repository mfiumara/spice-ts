***************************************************
* This version will be run without the -hspice-ext
* command line option.  So, the a and A on the R1
* and R2 lines will be ignored.
*
* See SON Bugs 472 and 1136 for more details.
*
***************************************************
V1 1 0 1
R1 1 2 1a
R2 2 0 1A

.DC V1 1 5 1

.print DC format=csv file=output.csv precision=17 {V1} I(v1) V(1) V(2)
.END
