* /home/fossee/esim-workspace/rlc/rlc.cir

r1  in net-_l1-pad1_ 1k
l1  net-_l1-pad1_ out 2
c1  out gnd 0.5u
v1  in gnd pwl(0m 0 0.5m 5)
* u1  in plot_v1
* u2  out plot_v1
.tran 10e-03 100e-03 0e-03

* Control Statements
.print TRAN format=csv file=output.csv precision=17 I(l1) I(v1) V(in) V(net-_l1-pad1_) V(out)
.end
