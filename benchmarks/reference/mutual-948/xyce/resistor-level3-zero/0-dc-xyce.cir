A simple test case of a resistor with zero resistance

* test case when resistance is given a zero
V1 a 0 5V
R1 a b 0
R2 b 0 1K

.DC V1 0 5V 1V

.print DC format=csv file=output.csv precision=17 {V1} I(v1) V(a) V(b)
.END
