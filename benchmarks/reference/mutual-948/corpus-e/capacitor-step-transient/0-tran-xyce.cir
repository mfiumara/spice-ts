'c check
v1 1 0 dc pulse(0 1 0 .01 .01 1k 1k) ac 1
r1 1 2 1
c2 2 0 1
*.tran .1 1 0
.tran 1 10 0
*.tran 10 100 0
.print TRAN format=csv file=output.csv precision=17 I(v1) V(1) V(2)
.end
