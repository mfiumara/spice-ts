simple diode test
V1   1  0  10.
R1   1  2  100.K
D1   2  0  ddd   m=2.
.model  ddd  d  ( is= 10.f  rs= 0.  n= 1.  tt= 0.  cjo= 1.p  vj= 1.  m= 0.5
+ eg= 1.11  xti= 3.  kf= 0.  af= 1.  fc= 0.5 )
.dc v1 -10 10 2
.end
