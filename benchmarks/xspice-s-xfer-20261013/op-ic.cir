s_xfer bounded contract
v1 in 0 dc 1 ac 1
a1 in out f
.model f s_xfer(num_coeff=[2 3] den_coeff=[2 4 6] int_ic=[5 7] gain=3)
r1 out 0 1k

.op
.end
