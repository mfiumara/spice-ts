local-reads-caller
.subckt leaf a b
R1 a b {rr}
.param rr={pp*2}
.ends leaf
.subckt rc in out gnd
.param pp=3k
X1 in out leaf
R2 out gnd 1k
.ends rc
V1 in 0 1
X1 in o 0 rc
.op
.end
