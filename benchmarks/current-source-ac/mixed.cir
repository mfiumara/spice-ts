Mixed voltage and independent current-source AC superposition
V1 source 0 AC 1 15
R1 source out 2
I1 out 0 AC 0.25 -30
I2 0 out AC 0.1 90
R2 out 0 3
.ac dec 5 10 100k
.end
