* Reconstructed published case: dc-wheatstone
V1 1 0 DC 24
R1 1 2 150
R2 1 3 50
R3 2 3 100
R4 2 0 300
R5 3 0 250
.dc V1 24 24 1
.end
