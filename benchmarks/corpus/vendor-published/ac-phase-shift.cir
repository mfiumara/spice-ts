* Reconstructed published case: ac-phase-shift
V1 1 0 AC 4
RSHUNT1 1 2 1
RSHUNT2 1 3 1
L1 2 0 1
R1 3 0 6.3k
.ac lin 1 1000 1000
.end
