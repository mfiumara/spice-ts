rc_osc test
* [xyce-to-spice3] SPICE3/ngspice-dialect translation of a Xyce Regression Suite netlist.
* [xyce-to-spice3] Upstream: https://github.com/Xyce/Xyce_Regression/blob/7bb7e98f0ed3a81a7d1cf1d10b68592107ed40b2/Netlists/CAPACITOR/rc_osc.cir
* [xyce-to-spice3] Verbatim original: benchmarks/corpus/xyce/fixtures/CAPACITOR/rc_osc.cir (sha256 add8ca9d2654398a4c394bc9232809677b479fe35172c66bbb8e2ad9bf9410a4)
* [xyce-to-spice3] Copyright 2019 National Technology & Engineering Solutions of Sandia, LLC (NTESS).
* [xyce-to-spice3] Licensed GPL-3.0-or-later; see benchmarks/corpus/xyce-spice3/LICENSE-NOTICE.md and COPYING.txt.
* [xyce-to-spice3] Modified 2026-10-11 by benchmarks/translate/xyce-to-spice3.ts v1:
* [xyce-to-spice3]   - .tran print step 0 -> 4e-6 s ((TSTOP - TSTART)/50)
* [xyce-to-spice3]   - .print brace expressions -> referenced output variables (v(2))
* [xyce-to-spice3]   - removed Xyce `.options timeint reltol=1.0e-4 abstol=1e-4 method=7` (no SPICE3 TIMEINT package; both engines use default tolerances)
* [xyce-to-spice3] Topology, element values and models are unchanged; only the lines listed above changed.
* [xyce-to-spice3] original: .tran 0 2.0e-4
.tran 4e-6 2.0e-4
* [xyce-to-spice3] original: .print tran {v(2)+0.002}
.print tran v(2)
* [xyce-to-spice3] original: .options timeint reltol=1.0e-4 abstol=1e-4 method=7

*COMP {v(2)+0.002} reltol=1.0e-6 abstol=1.0e-6

v1 1 0 sin 0 1V 1e5 0 0
r1 1 2 1k
c1 2 0 2u

.end
