Regression test to show proper transient RC circuit
* [xyce-to-spice3] SPICE3/ngspice-dialect translation of a Xyce Regression Suite netlist.
* [xyce-to-spice3] Upstream: https://github.com/Xyce/Xyce_Regression/blob/7bb7e98f0ed3a81a7d1cf1d10b68592107ed40b2/Netlists/CAPACITOR/capacitor.cir
* [xyce-to-spice3] Verbatim original: benchmarks/corpus/xyce/fixtures/CAPACITOR/capacitor.cir (sha256 38b0d8271d4cef0f783be9a5ba0bc391c6d164fbe0dba9027e93927f0656e90b)
* [xyce-to-spice3] Copyright 2019 National Technology & Engineering Solutions of Sandia, LLC (NTESS).
* [xyce-to-spice3] Licensed GPL-3.0-or-later; see benchmarks/corpus/xyce-spice3/LICENSE-NOTICE.md and COPYING.txt.
* [xyce-to-spice3] Modified 2026-10-11 by benchmarks/translate/xyce-to-spice3.ts v1:
* [xyce-to-spice3]   - c1 IC=1 -> added `.ic v(1)=1` (Xyce applies device IC= without UIC)
* [xyce-to-spice3]   - .tran print step 0 -> 1e-4 s ((TSTOP - TSTART)/50)
* [xyce-to-spice3]   - removed Xyce `.options timeint reltol=1e-6 abstol=1e-6` (no SPICE3 TIMEINT package; both engines use default tolerances)
* [xyce-to-spice3] Topology, element values and models are unchanged; only the lines listed above changed.
********************************************************************************
* Tier No.:  1
* Directory/Circuit Name:  CAPACITOR/capacitor.cir
*
* Todd Coffey (circuit copied from Bug 128,280,908, Tom Russo)
*
* If this circuit is simulated correctly, the T=0 value of the voltage v(1)
* should be 1V, and it should decay to 0 with a time constant of 1ms, as
*   v(1)(T)=1V*exp(-t/1ms)
*
* The provided perl script will generate the correct analytic solution for this
* circuit.  Simply run as "./rc.cir.prn.gs.pl" and it will take the rc.cir.prn
* file and generate an rc.cir.prn.gs file which uses the same time points as in
* rc.cir.prn.
*
* The gold standard was generated from
* > ./rc.cir.prn.gs.pl
* > cp rc.cir.prn.gs ../../OutputData/CAPACITOR/rc.cir.prn
*
* These high relative and absolute tolerances are required to match the
* analytic solution.
*
********************************************************************************
c1 1 0 1uF IC=1
* [xyce-to-spice3] added: Xyce applies instance IC= without UIC; SPICE3 equivalent is .ic
.ic v(1)=1
R1 1 2 1K
v1 2 0 0V
.print tran v(1)
* [xyce-to-spice3] original: .tran 0 5ms
.tran 1e-4 5ms
* [xyce-to-spice3] original: .options timeint reltol=1e-6 abstol=1e-6
.end
