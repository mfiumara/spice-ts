Test circuit for N-Channel JFET
* [xyce-to-spice3] SPICE3/ngspice-dialect translation of a Xyce Regression Suite netlist.
* [xyce-to-spice3] Upstream: https://github.com/Xyce/Xyce_Regression/blob/7bb7e98f0ed3a81a7d1cf1d10b68592107ed40b2/Netlists/NJFET_DC/njfet.cir
* [xyce-to-spice3] Verbatim original: benchmarks/corpus/xyce/fixtures/NJFET_DC/njfet.cir (sha256 295e3d4208ea2d839acf4724473b921ef1706976b254912b6e8455508c65b412)
* [xyce-to-spice3] Copyright 2019 National Technology & Engineering Solutions of Sandia, LLC (NTESS).
* [xyce-to-spice3] Licensed GPL-3.0-or-later; see benchmarks/corpus/xyce-spice3/LICENSE-NOTICE.md and COPYING.txt.
* [xyce-to-spice3] Modified 2026-10-11 by benchmarks/translate/xyce-to-spice3.ts v1:
* [xyce-to-spice3]   - `.Step Vgs 0 -1.875 -0.625` -> outer sweep of the nested .dc
* [xyce-to-spice3]   - `.DC VDS 0 15 1` -> `.DC VDS 0 15 1 Vgs 0 -1.875 -0.625`
* [xyce-to-spice3] Topology, element values and models are unchanged; only the lines listed above changed.
***********************************
*
*Drain curves
Vds 1 0 0
* [xyce-to-spice3] original: .DC VDS 0 15 1
.DC VDS 0 15 1 Vgs 0 -1.875 -0.625
Vgs 2 0 0
* [xyce-to-spice3] original: .Step Vgs 0 -1.875 -0.625
*
Vidmon 1 1a 0
Vigmon 2 2a 0
Vismon 0 3 0
*
.PRINT DC V(1) V(2) I(Vidmon)
*
Jtest 1a 2a 3 SA2109
*
.MODEL SA2109 NJF
+ LEVEL=1
+ BETA= 0.00002690
+ VTO = -3.795
+ PB = 1.07
+ LAMBDA = 0.0181
+ B = 0.605;
+ RD = 338.0
+ RS = 232.0
+ FC = 0.5
+ IS = 1.393E-10
+ AF = 1.0
+ KF = 0.05
+ CGS= 0
+ CGD= 0
*
.END
