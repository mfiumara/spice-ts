MESA level 2 instance-order test, order B
vd1 d1 0 dc -1
vd2 d2 0 dc 1
vg  g  0 dc 0
z2 d2 g 0 mf l=1u w=20u
z1 d1 g 0 mf l=1u w=20u
.model mf nmf level=2 vto=-0.5 rd=20 rs=20

.op
.print op i(vd1) i(vd2)
.end
