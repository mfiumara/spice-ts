* A function's formal argument is replaced by a temperature-dependent .param of the same name

.temp 27
.param k = 'temper + 1'

* This substitutes 'temper + 1' for k instead of the parameter passed to twice()
.param twice(k) = '2*k'

* twice(3) is 6, so we expect R1 = 6 ohm and V1 delivers 1/6 = 0.1667 A. But ngspice
* rewrites the .param definition over r1 and evaluates twice(temper+1) regardless
* of what we pass to twice(). Thus, 2*(temper+1) is 2*(27+1)=56 ohms and the current
* prints as 0.0179 A.
R1 a 0 {twice(3)}

V1 a 0 1

.op
.print op all
.end
