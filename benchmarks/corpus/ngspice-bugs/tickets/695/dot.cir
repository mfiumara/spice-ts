* B-device convergence test not effective
.options ngbehavior=psa
.options savecurrents
.tran 1m 0.51 0.49 1m
.option RELTOL=1m

* A function engineered to give a slow convergence of Newton root-finding:
* Residual current proportional to (V - Vroot)**3, so dI/dV=0 at the root.
* Each iteration multiplies the voltage error by 2/3
.param dv=10m
.func f(v) { -(v/dv)**3 + v/1K }

I1 0 y 1m
R1 y 0 1K
B2 0 y I=((time<0.5)? 0: f(V(y)-1.1)+0.1m)
.end
