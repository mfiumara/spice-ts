RC filter
.options klu
v1 1 0 0 ac 1.0
r1 1 2 1k
r2 2 3 500
c1 3 0 10p
.options noacct
.pz 1 0 3 0 vol pz
.print pz all
.end
