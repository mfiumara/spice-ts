.title TEST

    V_Vss vss 0 DC 3.3

    A_PD zero PD           $ ENDLINE COMMENT \\
        .model PD d_pulldown // ENDLINE COMMENT \\

***** ENTIRE COMMENTED LINE  *****

    A_PU up PU
        .model PU d_pullup

.control
        tran 1m 1m
.endc

.end
