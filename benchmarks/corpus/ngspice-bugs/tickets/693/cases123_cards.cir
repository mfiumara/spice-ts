* multiplicities: cases 1-3 of the #693 deck (case 4/5 use a subckt parameter named m)
i1 1 0 DC 1
r1 1 0 1 m=10

i2 2 0 DC 1
.subckt rx2 a b
r2 a b 1
.ends
x2 2 0 rx2 m=10

i3 3 0 DC 1
.subckt rx3 a b
r3 a b 1 m=2
.ends
x3 3 0 rx3 m=5
.op
.print op v(1) v(2) v(3)
.end
