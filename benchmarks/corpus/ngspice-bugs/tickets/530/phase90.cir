.title TEST PULSE
v1 1 0 0 PULSE(0 1 0 0.000001 0.000001 0.000999 0.002 90)
.tran 1 0.004
.end
