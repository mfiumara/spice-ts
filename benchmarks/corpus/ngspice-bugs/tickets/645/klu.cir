A simple bipolar circuit
.options klu
* Tadej Tuma, Árpád Burmen "Circuit Simulation with SPICE OPUS: Theory and Practice"
* Boston 2009

v1 1 0 dc=5
r1 1 2 r=1k
q1 2 3 0 t2n2222
r2 3 4 r=1k
vin 4 0 dc=0.68 ac 1

.model t2n2222 npn
+ is=19f bf=150 vaf=100 ikf=0.18 ise=50p
+ ne=2.5 br=7.5 var=6.4 ikr=12m isc=8.7p
+ nc=1.2 rb=50 re=0.4 rc=0.3 cje=26p tf=0.5n
+ cjc=11p tr=7n xtb=1.5 kf=0.032f af=1

.noise v(2) vin dec 10 0.5 100meg 1
.print noise onoise_spectrum inoise_spectrum
.end
