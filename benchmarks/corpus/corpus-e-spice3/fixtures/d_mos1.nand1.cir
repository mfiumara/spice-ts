.title na2
* SPICE3 (ngspice-dialect) translation of Gnucap tests/d_mos1.nand1.ckt at gnucap/gnucap@5acb027125d6ea7c546badd03e026d8781c6a400.
* Original: Gnucap regression tests, GPL-3.0-or-later (see LICENSE-NOTICE.MakeList and COPYING.txt here).
* Modified 2026-10-11 by benchmarks/translate/gnucap-to-spice3.ts (spice-ts issue #524); changes:
*   - commented out `.print op v(nodes) z(5) iter(0)` (SPICE3 has no `.print op`; the raw file still holds every node voltage and source current)
*   - `.op trace iter`: removed Gnucap `trace iter` console-trace option
*   - commented out `.print op Cgs(Mp1.XI10) Cgd(Mp1.XI10) Cgb(Mp1.XI10)` (SPICE3 has no `.print op`; the raw file still holds every node voltage and source current)
*   - commented out `.print op Cgs(Mp2.XI10) Cgd(Mp2.XI10) Cgb(Mp2.XI10)` (SPICE3 has no `.print op`; the raw file still holds every node voltage and source current)
*   - commented out `.print op Cgs(Mn1.XI10) Cgd(Mn1.XI10) Cgb(Mn1.XI10)` (SPICE3 has no `.print op`; the raw file still holds every node voltage and source current)
*   - commented out `.print op Cgs(Mn2.XI10) Cgd(Mn2.XI10) Cgb(Mn2.XI10)` (SPICE3 has no `.print op`; the raw file still holds every node voltage and source current)
*   - `.print tran v(2) v(4) v(5) iter(0)`: Gnucap-only probes iter(0) dropped (no SPICE3 output-variable syntax)
*   - `.tran 0.1n 10n trace all`: removed Gnucap console-trace option `trace all`
*   - commented out `.stat notime` (Gnucap `.stat` only prints solver statistics)
* The first line above is the unchanged original title line.

.model nmos nmos level=1 vto=0.7
.model pmos pmos level=1 vto=-0.7

.SUBCKT nand2 2 3 1 4 11
Mp1 4 2 1 1 PMOS W=8e-6 L=600e-9
Mp2 4 3 1 1 PMOS W=8e-6 L=600e-9
Mn1 4 2 11 0 NMOS W=8e-6 L=600e-9
Mn2 11 3 0 0 NMOS W=8e-6 L=600e-9
.ENDS

XI10 2 2 1 4 5 nand2
C1 4 0 1p

vdd 1 0 5
vin 2 0 PWL (0 0, 1n 0, 3n 5, 10n 5, 12n 0, 20n 0)

*gnucap-only: .print op v(nodes) z(5) iter(0)
.op

*gnucap-only: .print op Cgs(Mp1.XI10) Cgd(Mp1.XI10) Cgb(Mp1.XI10)
.op
*gnucap-only: .print op Cgs(Mp2.XI10) Cgd(Mp2.XI10) Cgb(Mp2.XI10)
.op
*gnucap-only: .print op Cgs(Mn1.XI10) Cgd(Mn1.XI10) Cgb(Mn1.XI10)
.op
*gnucap-only: .print op Cgs(Mn2.XI10) Cgd(Mn2.XI10) Cgb(Mn2.XI10)
.op

.print tran v(2) v(4) v(5)
.tran 0.1n 10n

*gnucap-only: .stat notime
.end
