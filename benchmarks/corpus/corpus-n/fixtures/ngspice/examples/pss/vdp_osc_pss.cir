Van Der Pol Oscillator
* Prediceted frequency is about 4.54167e+06 Hz.

* Third harmonic is as high as the first one
Ba  gib 0   I=-1e-2*v(gib,0)+1e-2*v(gib,0)^3
* Q is about 10
RLa gib gib1 1m
La  gib1 0  1.2e-6
Ra  gib 0   158.113
Ca  gib 0   1e-9 ic=-1

Vnew 0 gr 1
Rnew gr gib 5k

*La gib 0   1e-9
*Ra gib 0   474.6
*Ca gib 0   1e-9 ; ic=0.5
* Ghost node... Test for my PSS!
*Rb bad 0   1k

.tran 10e-9 20e-6 uic
.pss 0.5e6 100e-6 1 50 10 50 5e-3 uic

.end
