* independent current-source polarity DC sweep
I1 out 0 DC 0
R1 out 0 1k
.dc I1 -1m 1m 1m
.end
