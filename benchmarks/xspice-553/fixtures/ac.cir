xspice slice 2 ac
v1 1 0 DC 0.5 AC 1
v2 2 0 DC 10.0
v3 3 0 DC -10.0
v4 4 0 DC 1.25 AC 0.5
a1 1 10 hyst1
.model hyst1 hyst (in_low=0.0 in_high=1.0 hyst=0.1 out_lower_limit=0.0 out_upper_limit=2.0 input_domain=0.01 fraction=TRUE)
a2 1 4 3 20 climit2
.model climit2 climit (in_offset=0.1 gain=2.0 upper_delta=0.2 lower_delta=0.1 limit_range=0.2 fraction=FALSE)
a3 1 2 3 30 ilimit1
.model ilimit1 ilimit (gain=3.0 r_out_source=1.0 r_out_sink=1.0 i_limit_source=1e-2 i_limit_sink=1.5e-2 v_pwr_range=1e-3 i_source_range=1e-5 i_sink_range=1e-5 r_out_domain=1e-3)
a4 1 40 slew1
.model slew1 slew (rise_slope=1 fall_slope=1)
a5 1 50 sine1
.model sine1 sine (cntl_array=[0 1] freq_array=[1k 2k] out_low=-1 out_high=1)
r1 1 0 10k
r4 4 0 10k
r10 10 0 10k
r20 20 0 10k
r30 30 0 1k
r40 40 0 10k
r50 50 0 10k
.control
set numdgt=12
ac dec 1 10 1k
print v(10) v(20) v(30) v(40) v(50) i(v2) i(v3)
.endc
.end
