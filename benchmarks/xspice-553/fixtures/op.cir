xspice analog slice 2 op
v1 1 0 DC 1.0
v2 2 0 DC 10.0
v3 3 0 DC -10.0
v4 4 0 DC 0.55
v5 5 0 DC 1.3
a1 1 10 hyst1
.model hyst1 hyst (in_low=0.0 in_high=1.0 hyst=0.1 out_lower_limit=0.0 out_upper_limit=1.0 input_domain=0.01 fraction=TRUE)
a11 4 11 hyst2
.model hyst2 hyst (in_low=-1 in_high=2 hyst=0.3 out_lower_limit=-2 out_upper_limit=3 input_domain=0.05 fraction=FALSE)
a12 5 12 hyst2
a3 1 2 3 30 ilimit1
.model ilimit1 ilimit (in_offset=0.0 gain=1.0 r_out_source=1.0 r_out_sink=1.0 i_limit_source=1.0 i_limit_sink=1.0 v_pwr_range=1.0e-3 i_source_range=1.0e-3 i_sink_range=1.0e-3 r_out_domain=1.0e-3)
a31 5 2 3 31 ilimit2
.model ilimit2 ilimit (gain=4.0 r_out_source=2.0 r_out_sink=2.0 i_limit_source=5.0e-3 i_limit_sink=2e-3 v_pwr_range=1.0e-2 i_source_range=1.0e-4 i_sink_range=1.0e-4 r_out_domain=1.0e-2)
a32 4 null 3 32 ilimit2
a4 1 2 3 40 climit1
.model climit1 climit (in_offset=0.0 gain=1.0 upper_delta=0.0 lower_delta=0.0 limit_range=1.0e-6 fraction=FALSE)
a41 5 4 3 41 climit2
.model climit2 climit (in_offset=0.1 gain=2.0 upper_delta=0.2 lower_delta=0.1 limit_range=0.5 fraction=FALSE)
a42 4 1 3 42 climit3
.model climit3 climit (gain=2.0 upper_delta=0.0 lower_delta=0.0 limit_range=0.1 fraction=TRUE)
c5 51 0 1.0e-6
c52 51 53 2.5e-6
vz 51 54 0
c54 54 0 4e-7
r53 53 0 1k
r54 54 0 1k
a5 51 50 cmeter1
.model cmeter1 cmeter (gain=2.0)
l6 61 0 1.0e-6
l62 61 62 3.0e-6
r62 62 0 1
a6 61 60 lmeter1
.model lmeter1 lmeter (gain=1.0)
a7 5 70 slew1
.model slew1 slew (rise_slope=1e3 fall_slope=1e3)
r1 1 0 10k
r2 2 0 10k
r3 3 0 10k
r10 10 0 10k
r11 11 0 10k
r12 12 0 10k
r30 30 0 10k
r31 31 0 1k
r32 32 0 1k
r40 40 0 10k
r41 41 0 10k
r42 42 0 10k
r50 50 0 10k
r51 51 0 10k
r60 60 0 10k
r61 61 0 10k
r70 70 0 10k
.control
set numdgt=12
op
print all
.endc
.end
