DC temperature diode
V in 0 0.6
R in out 1k
D out 0 dm
.model dm d is=1e-14
.dc temp -40 160 40
.end
