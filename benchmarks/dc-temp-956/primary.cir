DC temperature diode
V out 0 0.6
D out 0 dm
.model dm d is=1e-14 n=2
.dc temp -40 160 40
.end
