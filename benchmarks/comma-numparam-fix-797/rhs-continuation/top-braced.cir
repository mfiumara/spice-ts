X-call continuation
.param seed=2.5
.subckt cell o params: alpha=1
I1 0 o {alpha}
R1 o 0 1
.ends
Xchild o cell alpha={seed
+*2}
.op
.end
