Issue 453 VBIC non-ground substrate DC sweep into parasitic latch-up
* Project-authored fixture: https://github.com/mfiumara/spice-ts/issues/453
* Model card: ngspice tests/vbic/CEamp.cir (BSD-3-Clause, rev 3ef069fb1f04177a153f342a32d941fc20ff047e)
Vcc 3 0 DC 2
Rc 3 2 1k
Vb 1 0 DC 0.75
Vsub 4 0 DC 0
Q1 2 1 0 4 N1
.MODEL N1 NPN LEVEL=4
+ IS=1e-16 IBEI=1e-18 IBEN=5e-15 IBCI=2e-17 IBCN=5e-15 ISP=1e-15 RCX=10
+ RCI=60 RBX=10 RBI=40 RE=2 RS=20 RBP=40 VEF=10 VER=4 IKF=2e-3 ITF=8e-2
+ XTF=20 IKR=2e-4 IKP=2e-4 CJE=1e-13 CJC=2e-14 CJEP=1e-13 CJCP=4e-13 VO=2
+ GAMM=2e-11 HRCF=2 QCO=1e-12 AVC1=2 AVC2=15 TF=10e-12 TR=100e-12 TD=2e-11 RTH=300
.dc Vsub -1 3 0.1
.print dc v(2) i(vcc) i(vb) i(vsub)
.end
