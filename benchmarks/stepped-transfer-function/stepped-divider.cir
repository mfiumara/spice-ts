Stepped transfer-function resistor divider
V1 in 0 DC 1
R1 in out 1k
R2 out 0 1k
.tf V(out) V1
.step param R2 list 500 1k 2k 4k
.end
