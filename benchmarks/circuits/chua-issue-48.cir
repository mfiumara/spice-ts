* Chua & Lin, 8-7 page 343
* Reconstructed from the LTspice schematic attached to spice-ts issue #48.
* Initial conditions confirmed in issue text: V(C12)=2 V, V(C3)=5 V.
.param V1dc=1 I1dc=1
V1 inp 0 {V1dc}
R10 inp x 0.5
C2 x 0 2
L8 x c 2H ic=2
C12 x y 5 ic=2
L9 y c 2H
C3 y 0 4 ic=5
R11 y out 0.25
R5 out 0 2
I1 0 out {I1dc}
L6 c n1 4H
R4 n1 0 1
K1 L6 L8 -0.3535534
K2 L6 L9 -0.3535534
K3 L8 L9 -0.5
.tran 0 200 0 0.2 uic
.options reltol=1e-12
.end
