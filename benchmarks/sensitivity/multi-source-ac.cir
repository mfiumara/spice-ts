Two non-zero AC source sensitivity regression
V1 in 0 DC 0 AC 1
V2 out 0 DC 0 AC 2
R1 in out 1k
R2 out 0 1k
.sens V(out) AC DEC 1 1 10
.end
