MESA level-2 RG/RI/RF and TS/TD in transient (issue #500, project-authored)
vdd 1 0 dc 1.6
rl 1 d 2k
vin g 0 pulse(0 0.6 1n 0.2n 0.2n 2n 5n)
z1 d g 0 mf l=1u w=20u ts=60 td=80
.model mf nmf level=2 vto=0.1 rd=20 rs=20 rg=15 ri=10 rf=12 lambda=0.1
+ sigma0=0.02 vsigmat=0.5 mu=0.25 d=1e-7 vs=1.9e5 n=1.3 alpha=0.2
.tran 0.01n 12n
.end
