MESA level-2 ALPHA in small signal (issue #500, project-authored)
vdd 1 0 dc 1.6
rl 1 d 2k
vin g 0 dc 0.35 ac 1
z1 d g 0 mf l=0.7u w=20u
.model mf nmf level=2 vto=0.1 lambda=0.1 sigma0=0.02 vsigmat=0.5 mu=0.25 d=1e-7
+ vs=1.9e5 n=1.3 alpha=0.3
.ac dec 10 1e3 1e11
.end
