Weakly grounded diode explicit gmin probe
Vbias high 0 5
Dreverse weak high generic
Dreturn 0 weak return
.model generic D
.model return D(is=2e-10 n=1.3)
.options gmin=1e-9 rshunt=1000000000000.5
.op
.end
