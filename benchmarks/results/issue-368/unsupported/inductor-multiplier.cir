* Issue 368 unsupported form: inductor multiplier instance parameter (project-authored, MIT)
V1 in 0 PULSE(0 1 0 1u 1u 10m 20m)
R1 in a 10
L1 a 0 2m m=2
.tran 1u 100u
.end
