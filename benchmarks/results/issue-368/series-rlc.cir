* Issue 368 bounded series RLC step transient (project-authored, MIT)
V1 in 0 PULSE(0 1 0 1u 1u 10m 20m)
R1 in a 10
L1 a out 1m
C1 out 0 1u
.tran 1u 400u
.end
