lateral PNP with a forward-biased ISS substrate junction, AC (issue 767)
vc c 0 -2
vb b 0 -0.85 ac 1
ve e 0 0
vs s 0 0
q1 c b e s qp
.model qp pnp is=22e-18 bf=215 iss=48e-18 cjs=315f
.control
set numdgt=12
ac dec 1 1e6 1e9
print i(vs) i(vb)
op
print i(vs) i(vb)
.endc
.end
