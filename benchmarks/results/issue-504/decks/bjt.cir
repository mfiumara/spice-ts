common emitter pz
vcc 4 0 12
vin 1 0 0 ac 1
rs 1 2 1k
cin 2 3 1u
rb1 4 3 100k
rb2 3 0 22k
q1 5 3 6 qn
rc 4 5 4.7k
re 6 0 1k
ce 6 0 10u
cl 5 0 10p
.model qn npn bf=100 is=1e-15 cje=2p cjc=1p tf=0.3n
.pz 1 0 5 0 vol pz
.end
