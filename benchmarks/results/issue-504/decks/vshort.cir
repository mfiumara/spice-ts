unsupported voltage-input device
V1 in 0 0
R1 in out 1k
C1 out 0 1n
.pz in 0 out 0 vol pz
.end
