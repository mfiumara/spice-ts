differential vol pz
r1 1 0 1k
r2 2 0 1k
c1 1 2 1n
r3 1 3 1k
c3 3 0 1n
r4 2 4 2k
c4 4 0 1n
.pz 1 2 3 4 vol pz
.end
