NHFET level-5 forward and inverse DC I-V (spice-ts issue #448)
* Single fixture-model device: VDS sweeps through inverse operation (VDS < 0)
* at three gate biases. Authored for spice-ts; no third-party content.
.subckt cell d g s
z1 d g s aload l=1u w=10u
.ends
vd d 0 dc 0
vg g 0 dc 0
x1 d g 0 cell
.model aload nhfet level=5 rd=60 rs=60 m=2.57 lambda=0.17
+ vs=1.5e5 mu=0.385 vt0=-0.3 eta=1.32 sigma0=0.04
+ vsigma=0.1 vsigmat=0.3 js1s=1e-12 js1d=1e-12
+ nmax=6e15
.dc vd -2.5 2.5 0.25 vg -0.3 0.3 0.3
.end
