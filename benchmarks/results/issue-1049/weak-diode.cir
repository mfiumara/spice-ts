Original weakly grounded diode experiment for #1049
* SPDX-License-Identifier: MIT
* Self-authored, generic values. Not a redistributed vendor model.
Vbias high 0 5
Dreverse weak high generic
Dreturn 0 weak return
.model generic D
.model return D(is=2e-10 n=1.3)
.options rshunt=1T
.op
.end
