MOS1 JS*AD/AS saturation-current scaling (issue 393)
VDD 5 0 DC 18
VGG 1 0 DC 1
RS 2 0 500
M1 5 1 2 2 NFET AD=2e-10 AS=3e-10
.MODEL NFET NMOS(LEVEL=1 KP=0.5M VTO=2 JS=1e-3)
.OP
.END
