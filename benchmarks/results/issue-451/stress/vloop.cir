cap across vsource plus rc
v1 4 0 0
c0 4 0 1n
r1 1 0 1k
r2 1 2 1k
c1 2 0 1n
r3 2 4 1k
c2 1 2 2n
.pz 1 0 2 0 cur pz
.print pz all
.end
