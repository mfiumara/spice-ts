two complex pairs
r1 1 0 1k
l1 1 2 1m
c1 2 0 1n
r2 2 3 10
l2 3 4 10u
c2 4 0 10p
r3 4 0 1k
.pz 1 0 4 0 cur pz
.print pz all
.end
