rlc lowpass relative degree 2
r1 1 0 50
l1 1 2 1u
c1 2 0 1n
r2 2 0 50
.pz 1 0 2 0 cur pz
.print pz all
.end
