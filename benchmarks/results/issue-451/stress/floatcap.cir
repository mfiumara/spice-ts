cap triangle loop
r1 1 0 1k
c1 1 2 1n
c2 2 3 1n
c3 3 1 1n
r2 2 0 2k
r3 3 0 3k
.pz 1 0 3 0 cur pz
.print pz all
.end
