diode reverse recovery with transit time
V1 in 0 PULSE(-1 1 0 1n 1n 20n 50n)
R1 in out 1k
D1 out 0 DM
.model DM D IS=1e-14 CJO=5p VJ=0.8 M=0.4 TT=5n
.tran 0.1n 50n
.control
run
set numdgt=12
linearize
print time v(out)
.endc
.end
