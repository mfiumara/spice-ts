nmf op points
vd d 0 1.0
vg g 0 0.3
z1 d g 0 driver l=0.7u w=20u
.model driver nmf level=2 n=1.44 vs=1.9e5
+ mu=0.25 d=1e-7 vto=0.15 m=2 lambda=0.15 sigma0=0.02
+ vsigmat=0.5
.control
foreach vgv -0.5 0.0 0.1 0.3 0.6 0.9
foreach vdv -0.4 0.0 0.05 0.5 1.6
alter vg dc = $vgv
alter vd dc = $vdv
op
echo REF $vgv $vdv
print i(vd) i(vg) @z1[gm] @z1[gds] @z1[ggs] @z1[ggd]
end
end
.endc
.end
