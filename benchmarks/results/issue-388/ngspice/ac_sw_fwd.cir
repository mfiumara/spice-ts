x
V1 in 0 DC 0.8 AC 1
R1 in out 1k
D1 out 0 DM PJ=1
.model DM D IS=1e-20 CJSW=10p
.ac dec 5 1e6 1e9
.control
run
set numdgt=12
print vm(out) vp(out)
.endc
.end
