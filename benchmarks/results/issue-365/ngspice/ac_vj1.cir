x
V1 in 0 DC -1 AC 1
R1 in out 1k
D1 out 0 DM
.model DM D IS=1e-14 CJO=10p VJ=1
.ac dec 5 1e6 1e9
.control
run
set numdgt=12
print vm(out) vp(out)
.endc
.end
