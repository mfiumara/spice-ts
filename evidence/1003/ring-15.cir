MOS 17 STAGE RING OSCILLATOR
**************************************************************************
**                                             **
**               ( MODEL M125CN )                    **
**                                             **
**     LEVEL II MOSFET PARAMETERS                         **
**     MCNC 1.25 CMOS PROCESS                              **
**     ( NOMINAL )                                   **
**                                             **
**************************************************************************

.model nenh nmos
+    Level=2            Ld=0.0u         Tox=225.000e-10
+    Nsub=1.066e+16     Vto=0.622490    Kp=6.326640E-05
+    Gamma=.639243      Phi=.31         Uo=1215.74
+    Uexp=4.612355e-2   Ucrit=174667    Delta=0.0
+    Vmax=177269        Xj=.9u          Lambda=0.0
+    Nfs=4.55168e+12    Neff=4.68830    Nss=3.000000E+10
+    Tpg=1              Rsh=60          Cgso=2.89e-10
+    Cgdo=2.89e-10      Cj=3.27e-04     Mj=1.067
+    Cjsw=1.74e-10      Mjsw=.195

.model penh pmos
+    Level=2            Ld=.03000000u   Tox=225.000e-10
+    Nsub=6.575441e+16  Vto=-0.63025    Kp=2.635440E-05
+    Gamma=0.618101     Phi=.541111     Uo=361.941
+    Uexp=8.886957e-02  Ucrit=637449    Delta=0.0
+    Vmax=63253.3       Xj=0.112799u    Lambda=0.
+    Nfs=1.668437e+11   Neff=0.64354    Nss=3.000000E+10
+    Tpg=-1             Rsh=150         Cgso=3.35e-10
+    Cgdo=3.35e-10      Cj=4.75e-04     Mj=.341
+    Cjsw=2.23e-10      Mjsw=.307

*
*
VDD 1 0 3
Mp1 3 2 1 1 penh l=1.25u w=5u ad=5p pd=6u as=5p ps=6u
Mn1 3 2 0 0 nenh l=1.25u w=5u ad=5p pd=6u as=5p ps=6u
Mp2 4 3 1 1 penh l=1.25u w=5u ad=5p pd=6u as=5p ps=6u
Mn2 4 3 0 0 nenh l=1.25u w=5u ad=5p pd=6u as=5p ps=6u
Mp3 5 4 1 1 penh l=1.25u w=5u ad=5p pd=6u as=5p ps=6u
Mn3 5 4 0 0 nenh l=1.25u w=5u ad=5p pd=6u as=5p ps=6u
Mp4 6 5 1 1 penh l=1.25u w=5u ad=5p pd=6u as=5p ps=6u
Mn4 6 5 0 0 nenh l=1.25u w=5u ad=5p pd=6u as=5p ps=6u
Mp5 7 6 1 1 penh l=1.25u w=5u ad=5p pd=6u as=5p ps=6u
Mn5 7 6 0 0 nenh l=1.25u w=5u ad=5p pd=6u as=5p ps=6u
Mp6 8 7 1 1 penh l=1.25u w=5u ad=5p pd=6u as=5p ps=6u
Mn6 8 7 0 0 nenh l=1.25u w=5u ad=5p pd=6u as=5p ps=6u
Mp7 9 8 1 1 penh l=1.25u w=5u ad=5p pd=6u as=5p ps=6u
Mn7 9 8 0 0 nenh l=1.25u w=5u ad=5p pd=6u as=5p ps=6u
Mp8 10 9 1 1 penh l=1.25u w=5u ad=5p pd=6u as=5p ps=6u
Mn8 10 9 0 0 nenh l=1.25u w=5u ad=5p pd=6u as=5p ps=6u
Mp9 11 10 1 1 penh l=1.25u w=5u ad=5p pd=6u as=5p ps=6u
Mn9 11 10 0 0 nenh l=1.25u w=5u ad=5p pd=6u as=5p ps=6u
Mp10 12 11 1 1 penh l=1.25u w=5u ad=5p pd=6u as=5p ps=6u
Mn10 12 11 0 0 nenh l=1.25u w=5u ad=5p pd=6u as=5p ps=6u
Mp11 13 12 1 1 penh l=1.25u w=5u ad=5p pd=6u as=5p ps=6u
Mn11 13 12 0 0 nenh l=1.25u w=5u ad=5p pd=6u as=5p ps=6u
Mp12 14 13 1 1 penh l=1.25u w=5u ad=5p pd=6u as=5p ps=6u
Mn12 14 13 0 0 nenh l=1.25u w=5u ad=5p pd=6u as=5p ps=6u
Mp13 15 14 1 1 penh l=1.25u w=5u ad=5p pd=6u as=5p ps=6u
Mn13 15 14 0 0 nenh l=1.25u w=5u ad=5p pd=6u as=5p ps=6u
Mp14 16 15 1 1 penh l=1.25u w=5u ad=5p pd=6u as=5p ps=6u
Mn14 16 15 0 0 nenh l=1.25u w=5u ad=5p pd=6u as=5p ps=6u
Mp15 2 16 1 1 penh l=1.25u w=5u ad=5p pd=6u as=5p ps=6u
Mn15 2 16 0 0 nenh l=1.25u w=5u ad=5p pd=6u as=5p ps=6u
C1 16 0 .1p
.ic v(2)=2 v(3)=0 v(4)=2 v(5)=0 v(6)=2 v(7)=0 v(8)=2 v(9)=0 v(10)=2 v(11)=0 v(12)=2 v(13)=0 v(14)=2 v(15)=0 v(16)=2
.tran .1ns 100ns
.end
